/*
* Deduplicator TX Register Map (SystemRDL 2.0 Specification)
* Module: tdl_tx_top
* CPU Interface: SPI (8-bit, Byte Addressing)
*/

addrmap tx_regs {
    name = "tdl_tx_top Registers";
    desc = "Карта регистров передатчика";
    littleendian;

    default regwidth    = 8;
    default accesswidth = 8;

    /* -------------------------------------------------------------------------
     * 0x00 - CTRL_REG (Control Register) - TX-Local (Немедленное действие)
     * ------------------------------------------------------------------------- */
    reg ctrl_reg_t {
        name = "Control Register";
        desc = "Глобальное управление передатчиком";

        field {
            name  = "TX_EN";
            desc  = "Включение передатчика: 1 = активен, 0 = заблокирован";
            sw    = rw; 
            hw    = r;
            reset = 1'b0;
        } tx_en[0:0];

        field {
            name  = "BYPASS_EN";
            desc  = "Режим сквозной передачи без дедупликации: 1 = включен, 0 = выключен";
            sw    = rw; 
            hw    = r;
            reset = 1'b0;
        } bypass_en[1:1];

        field {
            name  = "SOFT_RESET";
            desc  = "Программный сброс FSM и FIFO передатчика";
            sw    = rw; 
            hw    = r;
            reset = 1'b0;
        } soft_reset[2:2];

        field {
            name  = "RESERVED";
            desc  = "Зарезервировано";
            sw    = rw; 
            hw    = r;
            reset = 5'b00000;
        } reserved[7:3];
    };
    ctrl_reg_t CTRL_REG @ 0x00;

    /* -------------------------------------------------------------------------
     * 0x01 - MODE_REG (Algorithm Selection Register) - In-Band Sync
     * ------------------------------------------------------------------------- */
    reg mode_reg_t {
        name = "Mode Register";
        desc = "Выбор алгоритма дедупликации и параметры учета";

        field {
            name  = "ALGO_SEL";
            desc  = "Алгоритм: 00 = TinyLFU+CU-CMS, 01 = SLRU, 10 = Clock/CAR, 11 = Pure LFU";
            sw    = rw; 
            hw    = r;
            reset = 2'b00;
        } algo_sel[1:0];

        field {
            name  = "CU_DISABLE";
            desc  = "Отключение Conservative Update: 1 = стандартный CMS, 0 = CU включен";
            sw    = rw; 
            hw    = r;
            reset = 1'b0;
        } cu_disable[2:2];

        field {
            name  = "AGING_DISABLE";
            desc  = "Отключение автоматического затухания/деления на 2: 1 = отключено, 0 = включено";
            sw    = rw; 
            hw    = r;
            reset = 1'b0;
        } aging_disable[3:3];

        field {
            name  = "RESERVED";
            desc  = "Зарезервировано";
            sw    = rw; 
            hw    = r;
            reset = 4'b0000;
        } reserved[7:4];
    };
    mode_reg_t MODE_REG @ 0x01;

    /* -------------------------------------------------------------------------
     * 0x02 - AGING_PERIOD_LO (Младший байт периода затухания N)
     * ------------------------------------------------------------------------- */
    reg aging_period_lo_t {
        name = "Aging Period Low Byte";
        desc = "Младший байт периода затухания N (по умолчанию 1024 / 0x0400)";

        field {
            name  = "VAL";
            desc  = "Значение периода bits [7:0]";
            sw    = rw; 
            hw    = r;
            reset = 8'h00;
        } val[7:0];
    };
    aging_period_lo_t AGING_PERIOD_LO @ 0x02;

    /* -------------------------------------------------------------------------
     * 0x03 - AGING_PERIOD_HI (Старший байт периода затухания N)
     * ------------------------------------------------------------------------- */
    reg aging_period_hi_t {
        name = "Aging Period High Byte";
        desc = "Старший байт периода затухания N (по умолчанию 1024 / 0x0400)";

        field {
            name  = "VAL";
            desc  = "Значение периода bits [15:8]";
            sw    = rw; 
            hw    = r;
            reset = 8'h04;
        } val[7:0];
    };
    aging_period_hi_t AGING_PERIOD_HI @ 0x03;

    /* -------------------------------------------------------------------------
     * 0x04 - BF_CTRL_REG (Bloom Filter Control Register) - TX-Local / Strobes
     * ------------------------------------------------------------------------- */
    reg bf_ctrl_reg_t {
        name = "Bloom Filter Control Register";
        desc = "Управление фильтрами Блума и стробы очистки/ротации";

        field {
            name  = "BF_EN";
            desc  = "Включение фильтрации Блума: 1 = включено, 0 = выключено";
            sw    = rw; 
            hw    = r;
            reset = 1'b1;
        } bf_en[0:0];

        field {
            name  = "FORCE_ROTATE";
            desc  = "Принудительная ротация фильтров Блума (самосбрасываемый строб)";
            sw    = w; 
            hw    = r; 
            reset = 1'b0;
            singlepulse;
        } force_rotate[1:1];

        field {
            name  = "BF_RESET";
            desc  = "Полная очистка обоих фильтров Блума (самосбрасываемый строб)";
            sw    = w; 
            hw    = r; 
            reset = 1'b0;
            singlepulse;
        } bf_reset[2:2];

        field {
            name  = "RESERVED";
            desc  = "Зарезервировано";
            sw    = rw; 
            hw    = r;
            reset = 5'b00000;
        } reserved[7:3];
    };
    bf_ctrl_reg_t BF_CTRL_REG @ 0x04;

    /* -------------------------------------------------------------------------
     * 0x05 - SLRU_CFG_REG (SLRU Configuration)
     * ------------------------------------------------------------------------- */
    reg slru_cfg_reg_t {
        name = "SLRU Configuration Register";
        desc = "Порог деления словаря SLRU (Probationary vs Protected)";

        field {
            name  = "SLRU_THRESH";
            desc  = "Граница разделения сегментов (по умолчанию 0x40 = 64 ячейки)";
            sw    = rw; 
            hw    = r;
            reset = 8'h40;
        } slru_thresh[7:0];
    };
    slru_cfg_reg_t SLRU_CFG_REG @ 0x05;

    /* -------------------------------------------------------------------------
     * 0x06 - CMD_REG (Command Register) - Strobes
     * ------------------------------------------------------------------------- */
    reg cmd_reg_t {
        name = "Command Register";
        desc = "Стробы команд управления (WO Strobes, Auto-Clearing)";

        field {
            name  = "FLUSH_DICT_CMD";
            desc  = "Запрос синхронного сброса словарей (отправка 0xE4 по шине)";
            sw    = w; 
            hw    = r; 
            reset = 1'b0;
            singlepulse;
        } flush_dict_cmd[0:0];

        field {
            name  = "CLR_COUNTERS_CMD";
            desc  = "Однотактный импульс сброса всех счетчиков";
            sw    = w; 
            hw    = r; 
            reset = 1'b0;
            singlepulse;
        } clr_counters_cmd[1:1];

        field {
            name  = "RESERVED";
            desc  = "Зарезервировано";
            sw    = rw; 
            hw    = r;
            reset = 6'b00000;
        } reserved[7:2];
    };
    cmd_reg_t CMD_REG @ 0x06;

    /* -------------------------------------------------------------------------
     * 0x07 - STATUS_REG (Status Register) - Read Only
     * ------------------------------------------------------------------------- */
    reg status_reg_t {
        name = "Status Register";
        desc = "Флаги состояния FIFO и FSM передатчика";

        field {
            name  = "IN_FIFO_EMPTY";
            desc  = "Входное FIFO пусто";
            sw    = r; 
            hw    = w;
            reset = 1'b0;
        } in_fifo_empty[0:0];

        field {
            name  = "IN_FIFO_FULL";
            desc  = "Входное FIFO переполнено";
            sw    = r; 
            hw    = w;
            reset = 1'b0;
        } in_fifo_full[1:1];

        field {
            name  = "CONFIG_PENDING";
            desc  = "Наличие несинхронизированной конфигурации в STAGED_REG";
            sw    = r; 
            hw    = w;
            reset = 1'b0;
        } config_pending[2:2];

        field {
            name  = "FLUSH_BUSY";
            desc  = "Флаг выполнения сброса словаря и отправки 0xE4";
            sw    = r; 
            hw    = w;
            reset = 1'b0;
        } flush_busy[3:3];

        field {
            name  = "RESET_BUSY";
            desc  = "Процесс аппаратной инициализации BRAM";
            sw    = r; 
            hw    = w;
            reset = 1'b0;
        } reset_busy[4:4];

        field {
            name  = "FSM_STATE";
            desc  = "Текущий код состояния FSM кодера";
            sw    = r; 
            hw    = w;
            reset = 3'b000;
        } fsm_state[7:5];
    };
    status_reg_t STATUS_REG @ 0x07;

    /* -------------------------------------------------------------------------
     * 0x08 - INT_ENABLE_REG (Interrupt Enable Register)
     * ------------------------------------------------------------------------- */
    reg int_enable_reg_t {
        name = "Interrupt Enable Register";
        desc = "Маска разрешений прерываний передатчика";

        field {
            name  = "FIFO_OVERFLOW";
            desc  = "Разрешение прерывания при полном входном FIFO и паузе опроса датчиков";
            sw    = rw; 
            hw    = r;
            reset = 1'b0;
        } fifo_overflow[0:0];

        field {
            name  = "RESERVED";
            desc  = "Зарезервировано";
            sw    = rw; 
            hw    = r;
            reset = 1'b0;
        } reserved_1[1:1];

        field {
            name  = "AGING_EVENT";
            desc  = "Разрешение прерывания по циклу ротации/затухания";
            sw    = rw; 
            hw    = r;
            reset = 1'b0;
        } aging_event[2:2];

        field {
            name  = "HIGH_HIT_RATE";
            desc  = "Разрешение прерывания по превышению порога hit rate";
            sw    = rw; 
            hw    = r;
            reset = 1'b0;
        } high_hit_rate[3:3];

        field {
            name  = "SPI_ADDR_ERR";
            desc  = "Разрешение прерывания по обращению к незарезервированному адресу";
            sw    = rw; 
            hw    = r;
            reset = 1'b0;
        } spi_addr_err[4:4];

        field {
            name  = "I2C_NACK";
            desc  = "Разрешение прерывания по NACK от датчика I2C";
            sw    = rw;
            hw    = r;
            reset = 1'b0;
        } i2c_nack[5:5];

        field {
            name  = "I2C_TIMEOUT";
            desc  = "Разрешение прерывания по таймауту транзакции I2C";
            sw    = rw;
            hw    = r;
            reset = 1'b0;
        } i2c_timeout[6:6];

        field {
            name  = "I2C_BUS_ERR";
            desc  = "Разрешение прерывания по ошибке или зависанию шины I2C";
            sw    = rw;
            hw    = r;
            reset = 1'b0;
        } i2c_bus_err[7:7];
    };
    int_enable_reg_t INT_ENABLE_REG @ 0x08;

    /* -------------------------------------------------------------------------
     * 0x09 - INT_STATUS_REG (Interrupt Status Register) - W1C
     * ------------------------------------------------------------------------- */
    reg int_status_reg_t {
        name = "Interrupt Status Register";
        desc = "Статус прерываний передатчика (Запись '1' сбрасывает бит)";

        field {
            name    = "FIFO_OVERFLOW";
            desc    = "Входное FIFO заполнено, опрос датчиков приостановлен";
            sw      = rw; 
            hw      = rw;
            onwrite = woclr; 
            reset   = 1'b0;
        } fifo_overflow[0:0];

        field {
            name  = "RESERVED";
            desc  = "Зарезервировано";
            sw    = rw;
            hw    = r;
            reset = 1'b0;
        } reserved_1[1:1];

        field {
            name    = "AGING_EVENT";
            desc    = "Зафиксирован цикл затухания/ротации Блума";
            sw      = rw; 
            hw      = rw;
            onwrite = woclr; 
            reset   = 1'b0;
        } aging_event[2:2];

        field {
            name    = "HIGH_HIT_RATE";
            desc    = "Зафиксировано превышение порога hit rate";
            sw      = rw; 
            hw      = rw;
            onwrite = woclr; 
            reset   = 1'b0;
        } high_hit_rate[3:3];

        field {
            name    = "SPI_ADDR_ERR";
            desc    = "Зафиксировано обращение к незарезервированному адресу";
            sw      = rw; 
            hw      = rw;
            onwrite = woclr; 
            reset   = 1'b0;
        } spi_addr_err[4:4];

        field {
            name    = "I2C_NACK";
            desc    = "Зафиксирован NACK от датчика I2C";
            sw      = rw;
            hw      = rw;
            onwrite = woclr;
            reset   = 1'b0;
        } i2c_nack[5:5];

        field {
            name    = "I2C_TIMEOUT";
            desc    = "Зафиксирован таймаут транзакции I2C";
            sw      = rw;
            hw      = rw;
            onwrite = woclr;
            reset   = 1'b0;
        } i2c_timeout[6:6];

        field {
            name    = "I2C_BUS_ERR";
            desc    = "Зафиксирована ошибка или зависание шины I2C";
            sw      = rw;
            hw      = rw;
            onwrite = woclr;
            reset   = 1'b0;
        } i2c_bus_err[7:7];
    };
    int_status_reg_t INT_STATUS_REG @ 0x09;

    /* -------------------------------------------------------------------------
     * 0x0A - CRC_CFG_REG (CRC Configuration Register) - In-Band Sync
     * ------------------------------------------------------------------------- */
    reg crc_cfg_reg_t {
        name = "CRC Configuration Register";
        desc = "Настройка режима расчета и передачи контрольных сумм CRC";

        field {
            name  = "CRC_EN";
            desc  = "1 = Включение контроля CRC, 0 = Отключение";
            sw    = rw; 
            hw    = r;
            reset = 1'b1;
        } crc_en[0:0];

        field {
            name  = "CRC_MODE";
            desc  = "Режим: 00 = Idle/Pause, 01 = Block Mode, 10 = Continuous Mode";
            sw    = rw; 
            hw    = r;
            reset = 2'b00;
        } crc_mode[2:1];

        field {
            name  = "BLOCK_SIZE";
            desc  = "Длина блока M: 000=8, 001=16, 010=32, 011=64 слов";
            sw    = rw; 
            hw    = r;
            reset = 3'b000;
        } block_size[5:3];

        field {
            name  = "RESERVED";
            desc  = "Зарезервировано";
            sw    = rw; 
            hw    = r;
            reset = 2'b00;
        } reserved[7:6];
    };
    crc_cfg_reg_t CRC_CFG_REG @ 0x0A;

    /* -------------------------------------------------------------------------
     * 0x0B - HIT_RATE_THRESH_REG (Hit Rate Threshold)
     * ------------------------------------------------------------------------- */
    reg hit_rate_thresh_reg_t {
        name = "Hit Rate Threshold Register";
        desc = "Порог срабатывания прерывания HIGH_HIT_RATE (0..255)";

        field {
            name  = "THRESH_VAL";
            desc  = "Значение порога (255 = 100%)";
            sw    = rw; 
            hw    = r;
            reset = 8'h80;
        } thresh_val[7:0];
    };
    hit_rate_thresh_reg_t HIT_RATE_THRESH_REG @ 0x0B;

    /* -------------------------------------------------------------------------
     * 32-битные счетчики метрик (Read-Shadowed / Latch-on-Read, по 4 байта)
     * ------------------------------------------------------------------------- */
   
    reg cnt_32_t {
        name = "32-bit Performance Counter";
        regwidth    = 32; // Явно указываем 32 бита для данного типа регистра
        accesswidth = 8;  // Доступ по 8-битному SPI
        field {
            name  = "VAL";
            desc  = "32-битное значение счетчика";
            sw    = r; 
            hw    = w;
            reset = 32'h00000000;
        } val[31:0] = 32'h00000000;
    };

    cnt_32_t CNT_TOTAL_WORDS  @ 0x0C;
    cnt_32_t CNT_KEY_FRAMES   @ 0x10;
    cnt_32_t CNT_RAW_FRAMES   @ 0x14;
    cnt_32_t CNT_SYNC_FRAMES  @ 0x18;
    cnt_32_t CNT_BF_FILTERED  @ 0x1C;

    /* -------------------------------------------------------------------------
     * 0x20 - 0x21 - SDR clock divider (16-bit, little endian)
     * ------------------------------------------------------------------------- */
    reg sdr_clk_div_lo_t {
        name = "SDR Clock Divider Low Byte";
        desc = "Младший байт 16-битного делителя частоты SDR";
        field {
            name  = "VAL";
            desc  = "Биты [7:0] делителя SDR";
            sw    = rw;
            hw    = r;
            reset = 8'h00;
        } val[7:0];
    } SDR_CLK_DIV_LO @ 0x20;

    reg sdr_clk_div_hi_t {
        name = "SDR Clock Divider High Byte";
        desc = "Старший байт 16-битного делителя частоты SDR";
        field {
            name  = "VAL";
            desc  = "Биты [15:8] делителя SDR";
            sw    = rw;
            hw    = r;
            reset = 8'h00;
        } val[7:0];
    } SDR_CLK_DIV_HI @ 0x21;

    /* -------------------------------------------------------------------------
     * 0x22 - I2C_CTRL_REG
     * ------------------------------------------------------------------------- */
    reg i2c_ctrl_reg_t {
        name = "I2C Control Register";
        desc = "Управление I2C-контроллером и циклическим опросом датчиков";
        field {
            name  = "I2C_EN";
            desc  = "Разрешение работы I2C-контроллера";
            sw    = rw;
            hw    = r;
            reset = 1'b0;
        } i2c_en[0:0];
        field {
            name  = "POLL_EN";
            desc  = "Запуск циклического опроса датчиков";
            sw    = rw;
            hw    = r;
            reset = 1'b0;
        } poll_en[1:1];
        field {
            name  = "RESERVED";
            desc  = "Зарезервировано";
            sw    = rw;
            hw    = r;
            reset = 6'b000000;
        } reserved[7:2];
    } I2C_CTRL_REG @ 0x22;

    /* 16-bit I2C clock divider split into byte registers for 8-bit SPI access. */
    reg i2c_clk_div_byte_t {
        name = "I2C Clock Divider Byte";
        desc = "Байт 16-битного делителя частоты I2C от системных 50 МГц";
        field {
            name  = "VAL";
            desc  = "Байт значения делителя I2C";
            sw    = rw;
            hw    = r;
            reset = 8'hF9;
        } val[7:0];
    } I2C_CLK_DIV_LO @ 0x23;

    reg i2c_clk_div_hi_t {
        name = "I2C Clock Divider High Byte";
        desc = "Старший байт 16-битного делителя частоты I2C";
        field {
            name  = "VAL";
            desc  = "Биты [15:8] делителя I2C";
            sw    = rw;
            hw    = r;
            reset = 8'h00;
        } val[7:0];
    } I2C_CLK_DIV_HI @ 0x24;

    /* -------------------------------------------------------------------------
     * 0x25 - I2C_SENSOR_EN
     * ------------------------------------------------------------------------- */
    reg i2c_sensor_en_t {
        name = "I2C Sensor Enable Register";
        desc = "Маска разрешения опроса до четырех датчиков";
        field {
            name  = "SENSOR_EN";
            desc  = "Биты [3:0] разрешают опрос датчиков 0..3";
            sw    = rw;
            hw    = r;
            reset = 4'b0000;
        } sensor_en[3:0];
        field {
            name  = "RESERVED";
            desc  = "Зарезервировано";
            sw    = rw;
            hw    = r;
            reset = 4'b0000;
        } reserved[7:4];
    } I2C_SENSOR_EN @ 0x25;

    /* Per-sensor 7-bit I2C addresses. */
    reg i2c_sensor_addr_t {
        name = "I2C Sensor Address";
        desc = "7-битный адрес датчика на общей I2C-шине";
        field {
            name  = "ADDR";
            desc  = "7-битный адрес датчика";
            sw    = rw;
            hw    = r;
            reset = 7'h00;
        } addr[6:0];
        field {
            name  = "RESERVED";
            desc  = "Зарезервировано";
            sw    = rw;
            hw    = r;
            reset = 1'b0;
        } reserved[7:7];
    } I2C_SENSOR_ADDR0 @ 0x26;

    i2c_sensor_addr_t I2C_SENSOR_ADDR1 @ 0x27;
    i2c_sensor_addr_t I2C_SENSOR_ADDR2 @ 0x28;
    i2c_sensor_addr_t I2C_SENSOR_ADDR3 @ 0x29;

    /* -------------------------------------------------------------------------
     * 0x2A - I2C_STATUS_REG
     * ------------------------------------------------------------------------- */
    reg i2c_status_reg_t {
        name = "I2C Status Register";
        desc = "Текущее состояние I2C-опроса";
        field {
            name  = "BUSY";
            desc  = "Активна I2C-транзакция";
            sw    = r;
            hw    = w;
            reset = 1'b0;
        } busy[0:0];
        field {
            name  = "POLL_PAUSED";
            desc  = "Опрос приостановлен из-за заполнения входного FIFO";
            sw    = r;
            hw    = w;
            reset = 1'b0;
        } poll_paused[1:1];
        field {
            name  = "BUS_RECOVERY";
            desc  = "Выполняется восстановление I2C-шины";
            sw    = r;
            hw    = w;
            reset = 1'b0;
        } bus_recovery[2:2];
        field {
            name  = "RESERVED";
            desc  = "Зарезервировано";
            sw    = r;
            hw    = w;
            reset = 5'b00000;
        } reserved[7:3];
    } I2C_STATUS_REG @ 0x2A;

    /* -------------------------------------------------------------------------
     * 0x2B - I2C_TIMEOUT_REG
     * ------------------------------------------------------------------------- */
    reg i2c_timeout_reg_t {
        name = "I2C Timeout Register";
        desc = "Порог ожидания ответа датчика в тактах SCL";
        field {
            name  = "VAL";
            desc  = "Таймаут транзакции в тактах SCL; значение сброса равно 64";
            sw    = rw;
            hw    = r;
            reset = 8'h40;
        } val[7:0];
    } I2C_TIMEOUT_REG @ 0x2B;
};
